* NGSPICE file created from non_overlap_clk_flat.ext - technology: sky130A

.subckt non_overlap_clk CLK PHI1 PHI1_B PHI2 PHI2_B VDD VSS
X0 VSS XNAND_B.A PHI1 VSS sky130_fd_pr__nfet_01v8 ad=0.165 pd=1.33 as=0.31 ps=2.62 w=1 l=0.15
X1 VSS XDA4.A XDA4.Y VSS sky130_fd_pr__nfet_01v8 ad=0.174 pd=1.78 as=0.174 ps=1.78 w=0.6 l=0.95
X2 VDD XNAND_B.B XNAND_B.Y VDD sky130_fd_pr__pfet_01v8 ad=0.58 pd=4.58 as=0.58 ps=4.58 w=2 l=0.15
X3 VSS PHI2 PHI2_B VSS sky130_fd_pr__nfet_01v8 ad=0.165 pd=1.33 as=0.31 ps=2.62 w=1 l=0.15
X4 VDD XNAND_B.A PHI1 VDD sky130_fd_pr__pfet_01v8 ad=0.495 pd=3.33 as=0.93 ps=6.62 w=3 l=0.15
X5 VDD XDB1.Y XDB2.Y VDD sky130_fd_pr__pfet_01v8 ad=0.435 pd=3.58 as=0.435 ps=3.58 w=1.5 l=0.95
X6 VDD XDB3.Y XDB4.Y VDD sky130_fd_pr__pfet_01v8 ad=0.435 pd=3.58 as=0.435 ps=3.58 w=1.5 l=0.95
X7 VDD XDB4.Y XDB5.Y VDD sky130_fd_pr__pfet_01v8 ad=0.435 pd=3.58 as=0.435 ps=3.58 w=1.5 l=0.95
X8 VSS XNAND_B.B a_n3305_n2360# VSS sky130_fd_pr__nfet_01v8 ad=0.464 pd=3.78 as=0.464 ps=3.78 w=1.6 l=0.15
X9 VDD XDA4.Y XDA6.A VDD sky130_fd_pr__pfet_01v8 ad=0.435 pd=3.58 as=0.435 ps=3.58 w=1.5 l=0.95
X10 VSS XDB5.Y XDB6.Y VSS sky130_fd_pr__nfet_01v8 ad=0.174 pd=1.78 as=0.174 ps=1.78 w=0.6 l=0.95
X11 a_n3305_1340# CLK XNAND_A.Y VSS sky130_fd_pr__nfet_01v8 ad=0.464 pd=3.78 as=0.464 ps=3.78 w=1.6 l=0.15
X12 VSS XNAND_B.Y XDB1.Y VSS sky130_fd_pr__nfet_01v8 ad=0.174 pd=1.78 as=0.174 ps=1.78 w=0.6 l=0.95
X13 PHI2_B PHI2 VSS VSS sky130_fd_pr__nfet_01v8 ad=0.31 pd=2.62 as=0.165 ps=1.33 w=1 l=0.15
X14 VDD XDA2.A XDA2.Y VDD sky130_fd_pr__pfet_01v8 ad=0.435 pd=3.58 as=0.435 ps=3.58 w=1.5 l=0.95
X15 VDD XDB5.Y XDB6.Y VDD sky130_fd_pr__pfet_01v8 ad=0.435 pd=3.58 as=0.435 ps=3.58 w=1.5 l=0.95
X16 VDD XNAND_B.Y XDB1.Y VDD sky130_fd_pr__pfet_01v8 ad=0.435 pd=3.58 as=0.435 ps=3.58 w=1.5 l=0.95
X17 VDD CLK XNAND_B.B VDD sky130_fd_pr__pfet_01v8 ad=0.725 pd=5.58 as=0.725 ps=5.58 w=2.5 l=0.15
X18 VSS XDB6.Y PHI2 VSS sky130_fd_pr__nfet_01v8 ad=0.165 pd=1.33 as=0.31 ps=2.62 w=1 l=0.15
X19 VSS XNAND_A.Y XDA2.A VSS sky130_fd_pr__nfet_01v8 ad=0.174 pd=1.78 as=0.174 ps=1.78 w=0.6 l=0.95
X20 VSS XDA2.Y XDA4.A VSS sky130_fd_pr__nfet_01v8 ad=0.174 pd=1.78 as=0.174 ps=1.78 w=0.6 l=0.95
X21 PHI1_B PHI1 VSS VSS sky130_fd_pr__nfet_01v8 ad=0.31 pd=2.62 as=0.165 ps=1.33 w=1 l=0.15
X22 VDD XDB6.Y XNAND_A.Y VDD sky130_fd_pr__pfet_01v8 ad=0.58 pd=4.58 as=0.58 ps=4.58 w=2 l=0.15
X23 VDD XDA6.A XNAND_B.A VDD sky130_fd_pr__pfet_01v8 ad=0.435 pd=3.58 as=0.435 ps=3.58 w=1.5 l=0.95
X24 PHI2 XDB6.Y VSS VSS sky130_fd_pr__nfet_01v8 ad=0.31 pd=2.62 as=0.165 ps=1.33 w=1 l=0.15
X25 PHI1_B PHI1 VDD VDD sky130_fd_pr__pfet_01v8 ad=0.93 pd=6.62 as=0.495 ps=3.33 w=3 l=0.15
X26 VDD XDA4.A XDA4.Y VDD sky130_fd_pr__pfet_01v8 ad=0.435 pd=3.58 as=0.435 ps=3.58 w=1.5 l=0.95
X27 VDD PHI2 PHI2_B VDD sky130_fd_pr__pfet_01v8 ad=0.495 pd=3.33 as=0.93 ps=6.62 w=3 l=0.15
X28 VSS XDB2.Y XDB3.Y VSS sky130_fd_pr__nfet_01v8 ad=0.174 pd=1.78 as=0.174 ps=1.78 w=0.6 l=0.95
X29 VSS PHI1 PHI1_B VSS sky130_fd_pr__nfet_01v8 ad=0.165 pd=1.33 as=0.31 ps=2.62 w=1 l=0.15
X30 VSS XDA4.Y XDA6.A VSS sky130_fd_pr__nfet_01v8 ad=0.174 pd=1.78 as=0.174 ps=1.78 w=0.6 l=0.95
X31 VDD PHI1 PHI1_B VDD sky130_fd_pr__pfet_01v8 ad=0.495 pd=3.33 as=0.93 ps=6.62 w=3 l=0.15
X32 PHI2_B PHI2 VDD VDD sky130_fd_pr__pfet_01v8 ad=0.93 pd=6.62 as=0.495 ps=3.33 w=3 l=0.15
X33 VSS XDB6.Y a_n3305_1340# VSS sky130_fd_pr__nfet_01v8 ad=0.464 pd=3.78 as=0.464 ps=3.78 w=1.6 l=0.15
X34 VSS XDA2.A XDA2.Y VSS sky130_fd_pr__nfet_01v8 ad=0.174 pd=1.78 as=0.174 ps=1.78 w=0.6 l=0.95
X35 VDD XNAND_B.A XNAND_B.Y VDD sky130_fd_pr__pfet_01v8 ad=0.58 pd=4.58 as=0.58 ps=4.58 w=2 l=0.15
X36 VDD XDB2.Y XDB3.Y VDD sky130_fd_pr__pfet_01v8 ad=0.435 pd=3.58 as=0.435 ps=3.58 w=1.5 l=0.95
X37 PHI1 XNAND_B.A VSS VSS sky130_fd_pr__nfet_01v8 ad=0.31 pd=2.62 as=0.165 ps=1.33 w=1 l=0.15
X38 VDD XNAND_A.Y XDA2.A VDD sky130_fd_pr__pfet_01v8 ad=0.435 pd=3.58 as=0.435 ps=3.58 w=1.5 l=0.95
X39 VSS CLK XNAND_B.B VSS sky130_fd_pr__nfet_01v8 ad=0.29 pd=2.58 as=0.29 ps=2.58 w=1 l=0.15
X40 a_n3305_n2360# XNAND_B.A XNAND_B.Y VSS sky130_fd_pr__nfet_01v8 ad=0.464 pd=3.78 as=0.464 ps=3.78 w=1.6 l=0.15
X41 VDD CLK XNAND_A.Y VDD sky130_fd_pr__pfet_01v8 ad=0.58 pd=4.58 as=0.58 ps=4.58 w=2 l=0.15
X42 VDD XDA2.Y XDA4.A VDD sky130_fd_pr__pfet_01v8 ad=0.435 pd=3.58 as=0.435 ps=3.58 w=1.5 l=0.95
X43 PHI1 XNAND_B.A VDD VDD sky130_fd_pr__pfet_01v8 ad=0.93 pd=6.62 as=0.495 ps=3.33 w=3 l=0.15
X44 VDD XDB6.Y PHI2 VDD sky130_fd_pr__pfet_01v8 ad=0.495 pd=3.33 as=0.93 ps=6.62 w=3 l=0.15
X45 VSS XDB1.Y XDB2.Y VSS sky130_fd_pr__nfet_01v8 ad=0.174 pd=1.78 as=0.174 ps=1.78 w=0.6 l=0.95
X46 VSS XDA6.A XNAND_B.A VSS sky130_fd_pr__nfet_01v8 ad=0.174 pd=1.78 as=0.174 ps=1.78 w=0.6 l=0.95
X47 VSS XDB4.Y XDB5.Y VSS sky130_fd_pr__nfet_01v8 ad=0.174 pd=1.78 as=0.174 ps=1.78 w=0.6 l=0.95
X48 PHI2 XDB6.Y VDD VDD sky130_fd_pr__pfet_01v8 ad=0.93 pd=6.62 as=0.495 ps=3.33 w=3 l=0.15
X49 VSS XDB3.Y XDB4.Y VSS sky130_fd_pr__nfet_01v8 ad=0.174 pd=1.78 as=0.174 ps=1.78 w=0.6 l=0.95
C1 XNAND_B.B a_n3305_n2360# 0.05301f
C2 XDB6.Y VDD 3.12778f
C3 XDB6.Y XNAND_A.Y 0.50345f
C4 XDA6.A XDA4.Y 0.54082f
C5 VDD XDB4.Y 1.28412f
C6 XNAND_B.B XNAND_B.Y 0.29514f
C7 XDB6.Y CLK 0.82534f
C8 XNAND_B.Y XDB2.Y 0.05171f
C9 XDB6.Y PHI2 0.75401f
C10 a_n3305_1340# VDD 0.0166f
C11 XDA4.Y XDA2.Y 0.05623f
C12 a_n3305_1340# XNAND_A.Y 0.23704f
C14 a_n3305_1340# CLK 0.06072f
C15 XDB6.Y XDA2.A 0.04363f
C18 XDB5.Y XDB6.Y 0.59393f
C19 XDB5.Y XDB4.Y 0.54082f
C20 VDD XNAND_B.A 2.10064f
C21 XNAND_A.Y XNAND_B.A 0.00393f
C22 XNAND_B.A CLK 0.00128f
C24 XDA4.A VDD 1.40243f
C26 XNAND_B.A PHI1 0.71679f
C27 XNAND_B.B XDB1.Y 0.05285f
C28 XDB6.Y PHI2_B 0.00463f
C29 a_n3305_n2360# XNAND_B.A 0.05301f
C31 XNAND_B.Y XNAND_B.A 0.47697f
C33 XDB1.Y XDB2.Y 0.53665f
C35 XDA4.A XDA2.A 0.05623f
C37 XDB6.Y XDB1.Y 0.0016f
C39 VDD XDB3.Y 1.40243f
C40 VDD XNAND_A.Y 2.04534f
C41 VDD CLK 1.13951f
C42 XNAND_A.Y CLK 0.62938f
C43 XDA6.A XNAND_B.A 0.54571f
C44 XNAND_B.B XDB2.Y 0.0011f
C45 VDD PHI1 2.51114f
C46 XDA4.A XDA6.A 0.05623f
C47 PHI2 VDD 2.50869f
C50 XDB5.Y XDB3.Y 0.05623f
C51 PHI1_B XNAND_B.A 0.00269f
C52 XDB1.Y XNAND_B.A 0.0011f
C53 VDD a_n3305_n2360# 0.0166f
C54 XDA4.Y XNAND_B.A 0.06128f
C55 XDA2.A VDD 1.41152f
C56 XDA2.A XNAND_A.Y 0.53935f
C57 XNAND_B.B XDB6.Y 0.2457f
C58 XNAND_B.Y VDD 1.99631f
C59 XDA4.A XDA2.Y 0.54082f
C60 XDB5.Y VDD 1.41025f
C61 XDA2.A CLK 0.00401f
C62 XDA4.A XDA4.Y 0.53633f
C64 XDB2.Y XDB4.Y 0.05623f
C66 XDB5.Y PHI2 0.0453f
C67 XNAND_B.Y a_n3305_n2360# 0.23704f
C68 XDB6.Y XDB4.Y 0.06725f
C69 VDD PHI2_B 1.37058f
C70 XNAND_B.B XNAND_B.A 0.26488f
C71 XDA6.A VDD 1.4162f
C72 a_n3305_1340# XDB6.Y 0.05355f
C73 PHI2 PHI2_B 0.9715f
C75 XDB1.Y XDB3.Y 0.05623f
C76 XDA6.A PHI1 0.0506f
C77 VDD XDA2.Y 1.28409f
C78 XNAND_A.Y XDA2.Y 0.05171f
C79 VDD PHI1_B 1.37058f
C80 VDD XDB1.Y 1.40826f
C81 VDD XDA4.Y 1.28412f
C83 XDB6.Y XNAND_B.A 0.53838f
C85 PHI1_B PHI1 0.9715f
C88 XDA2.A XDA2.Y 0.53665f
C91 XNAND_B.Y XDB1.Y 0.5439f
C92 XNAND_B.B VDD 1.76144f
C93 XNAND_B.B XNAND_A.Y 0.01537f
C94 XDB2.Y XDB3.Y 0.54082f
C95 XNAND_B.B CLK 0.62162f
C96 VDD XDB2.Y 1.28409f
C98 XDB6.Y XDB3.Y 0.00238f
C99 XDB3.Y XDB4.Y 0.53633f
C100 PHI2_B VSS 3.63269f
C101 PHI1_B VSS 3.44239f
C102 VDD VSS 56.63983f
C103 a_n3305_n2360# VSS 0.64193f
C104 XDB4.Y VSS 0.51584f
C105 XDB2.Y VSS 0.81298f
C106 XNAND_B.Y VSS 0.5799f
C107 a_n3305_1340# VSS 1.78394f
C108 XNAND_B.A VSS 0.12907f
C109 XDA4.A VSS 0.36883f
.ends
