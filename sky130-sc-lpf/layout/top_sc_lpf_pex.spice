* NGSPICE file created from top_sc_lpf_flat.ext - technology: sky130A

.subckt top_sc_lpf VIN CLK IBIAS VOUT VDD VSS
X0 VSS VSS sky130_fd_pr__cap_mim_m3_1 l=9.85 w=4.85
X1 VSS VSS sky130_fd_pr__cap_mim_m3_1 l=9.85 w=4.85
X2 VDD CLK XCLK.XNAND_A.Y VDD sky130_fd_pr__pfet_01v8 ad=0.58 pd=4.58 as=0.58 ps=4.58 w=2 l=0.15
X3 VDD XCLK.XDB5.Y XCLK.XDB6.Y VDD sky130_fd_pr__pfet_01v8 ad=0.435 pd=3.58 as=0.435 ps=3.58 w=1.5 l=0.95
X4 VSS VSS sky130_fd_pr__cap_mim_m3_1 l=9.85 w=4.85
X5 a_7627_n1000# XOTA.INP a_7845_n1000# VSS sky130_fd_pr__nfet_01v8 ad=0.58 pd=4.29 as=0.58 ps=4.29 w=4 l=0.8
X6 VSS VSS sky130_fd_pr__cap_mim_m3_1 l=9.85 w=4.85
X7 IBIAS IBIAS VSS VSS sky130_fd_pr__nfet_01v8 ad=1.16 pd=8.58 as=0.58 ps=4.29 w=4 l=1
X8 a_7845_n1000# XOTA.INP a_7627_n1000# VSS sky130_fd_pr__nfet_01v8 ad=0.58 pd=4.29 as=0.58 ps=4.29 w=4 l=0.8
X9 VOUT VOUT a_7627_n1000# VSS sky130_fd_pr__nfet_01v8 ad=0.58 pd=4.29 as=0.58 ps=4.29 w=4 l=0.8
X10 VSS CLK XCLK.XNAND_B.B VSS sky130_fd_pr__nfet_01v8 ad=0.29 pd=2.58 as=0.29 ps=2.58 w=1 l=0.15
X11 VSS XSC.PHI2 XSC.PHI2_B VSS sky130_fd_pr__nfet_01v8 ad=0.165 pd=1.33 as=0.31 ps=2.62 w=1 l=0.15
X12 VDD XCLK.XNAND_B.B XCLK.XNAND_B.Y VDD sky130_fd_pr__pfet_01v8 ad=0.58 pd=4.58 as=0.58 ps=4.58 w=2 l=0.15
X13 VSS XCLK.XNAND_A.Y XCLK.XDA2.A VSS sky130_fd_pr__nfet_01v8 ad=0.174 pd=1.78 as=0.174 ps=1.78 w=0.6 l=0.95
X14 VSS XCLK.XDB1.Y XCLK.XDB2.Y VSS sky130_fd_pr__nfet_01v8 ad=0.174 pd=1.78 as=0.174 ps=1.78 w=0.6 l=0.95
X15 VSS VSS sky130_fd_pr__cap_mim_m3_1 l=9.85 w=4.85
X16 a_7627_n1000# VOUT VOUT VSS sky130_fd_pr__nfet_01v8 ad=0.58 pd=4.29 as=0.58 ps=4.29 w=4 l=0.8
X17 VDD XSC.PHI1 XSC.PHI1_B VDD sky130_fd_pr__pfet_01v8 ad=0.495 pd=3.33 as=0.93 ps=6.62 w=3 l=0.15
X18 VSS VSS sky130_fd_pr__cap_mim_m3_1 l=9.85 w=4.85
X19 XSC.PHI1_B XSC.PHI1 VDD VDD sky130_fd_pr__pfet_01v8 ad=0.93 pd=6.62 as=0.495 ps=3.33 w=3 l=0.15
X20 a_7845_n1000# XOTA.INP a_7627_n1000# VSS sky130_fd_pr__nfet_01v8 ad=0.58 pd=4.29 as=1.16 ps=8.58 w=4 l=0.8
X21 VOUT a_7845_n1000# VDD VDD sky130_fd_pr__pfet_01v8 ad=0.58 pd=4.29 as=0.58 ps=4.29 w=4 l=0.8
X22 VDD XCLK.XDA4.A XCLK.XDA4.Y VDD sky130_fd_pr__pfet_01v8 ad=0.435 pd=3.58 as=0.435 ps=3.58 w=1.5 l=0.95
X23 XOTA.INP VSS sky130_fd_pr__cap_mim_m3_1 l=9.85 w=4.85
X24 XOTA.INP XSC.PHI2 XSC.XTG1.VOUT VSS sky130_fd_pr__nfet_01v8 ad=0.165 pd=1.33 as=0.31 ps=2.62 w=1 l=0.15
X25 XOTA.INP XSC.PHI2_B XOTA.INP VSS sky130_fd_pr__nfet_01v8 ad=0.29 pd=2.58 as=0.91 ps=7.82 w=1 l=0.15
X26 VSS XCLK.XDA2.Y XCLK.XDA4.A VSS sky130_fd_pr__nfet_01v8 ad=0.174 pd=1.78 as=0.174 ps=1.78 w=0.6 l=0.95
X27 XSC.PHI1_B XSC.PHI1 VSS VSS sky130_fd_pr__nfet_01v8 ad=0.31 pd=2.62 as=0.165 ps=1.33 w=1 l=0.15
X28 VSS XCLK.XDB6.Y a_n14905_n460# VSS sky130_fd_pr__nfet_01v8 ad=0.464 pd=3.78 as=0.464 ps=3.78 w=1.6 l=0.15
X29 VSS XCLK.XNAND_B.B a_n14905_n4160# VSS sky130_fd_pr__nfet_01v8 ad=0.464 pd=3.78 as=0.464 ps=3.78 w=1.6 l=0.15
X30 VSS IBIAS a_7627_n1000# VSS sky130_fd_pr__nfet_01v8 ad=0.58 pd=4.29 as=0.58 ps=4.29 w=4 l=1
X31 VOUT VOUT a_7627_n1000# VSS sky130_fd_pr__nfet_01v8 ad=0.58 pd=4.29 as=0.58 ps=4.29 w=4 l=0.8
X32 XSC.PHI2 XCLK.XDB6.Y VDD VDD sky130_fd_pr__pfet_01v8 ad=0.93 pd=6.62 as=0.495 ps=3.33 w=3 l=0.15
X33 a_7627_n1000# IBIAS VSS VSS sky130_fd_pr__nfet_01v8 ad=0.58 pd=4.29 as=0.58 ps=4.29 w=4 l=1
X34 VSS XCLK.XDB4.Y XCLK.XDB5.Y VSS sky130_fd_pr__nfet_01v8 ad=0.174 pd=1.78 as=0.174 ps=1.78 w=0.6 l=0.95
X35 VDD a_7845_n1000# VOUT VDD sky130_fd_pr__pfet_01v8 ad=0.58 pd=4.29 as=0.58 ps=4.29 w=4 l=0.8
X36 VDD XCLK.XDB1.Y XCLK.XDB2.Y VDD sky130_fd_pr__pfet_01v8 ad=0.435 pd=3.58 as=0.435 ps=3.58 w=1.5 l=0.95
X37 XOTA.INP VSS sky130_fd_pr__cap_mim_m3_1 l=9.85 w=4.85
X38 a_7627_n1000# VOUT VOUT VSS sky130_fd_pr__nfet_01v8 ad=0.58 pd=4.29 as=0.58 ps=4.29 w=4 l=0.8
X39 VDD a_7845_n1000# a_7845_n1000# VDD sky130_fd_pr__pfet_01v8 ad=1.16 pd=8.58 as=0.58 ps=4.29 w=4 l=0.8
X40 a_n14905_n460# CLK XCLK.XNAND_A.Y VSS sky130_fd_pr__nfet_01v8 ad=0.464 pd=3.78 as=0.464 ps=3.78 w=1.6 l=0.15
X41 XOTA.INP XSC.PHI2_B XSC.XTG1.VOUT VDD sky130_fd_pr__pfet_01v8 ad=0.495 pd=3.33 as=0.93 ps=6.62 w=3 l=0.15
X42 XOTA.INP XSC.PHI2 XOTA.INP VDD sky130_fd_pr__pfet_01v8 ad=0.87 pd=6.58 as=2.73 ps=19.82 w=3 l=0.15
X43 VSS VSS sky130_fd_pr__cap_mim_m3_1 l=9.85 w=4.85
X44 a_7845_n1000# a_7845_n1000# VDD VDD sky130_fd_pr__pfet_01v8 ad=0.58 pd=4.29 as=1.16 ps=8.58 w=4 l=0.8
X45 VSS VSS sky130_fd_pr__cap_mim_m3_1 l=9.85 w=4.85
X46 VSS VSS sky130_fd_pr__cap_mim_m3_1 l=9.85 w=4.85
X47 XOTA.INP VSS sky130_fd_pr__cap_mim_m3_1 l=9.85 w=4.85
X48 a_7627_n1000# XOTA.INP a_7845_n1000# VSS sky130_fd_pr__nfet_01v8 ad=0.58 pd=4.29 as=0.58 ps=4.29 w=4 l=0.8
X49 VDD XCLK.XDB6.Y XSC.PHI2 VDD sky130_fd_pr__pfet_01v8 ad=0.495 pd=3.33 as=0.93 ps=6.62 w=3 l=0.15
X50 VSS XCLK.XNAND_B.Y XCLK.XDB1.Y VSS sky130_fd_pr__nfet_01v8 ad=0.174 pd=1.78 as=0.174 ps=1.78 w=0.6 l=0.95
X51 VDD XCLK.XNAND_A.Y XCLK.XDA2.A VDD sky130_fd_pr__pfet_01v8 ad=0.435 pd=3.58 as=0.435 ps=3.58 w=1.5 l=0.95
X52 XOTA.INP VSS sky130_fd_pr__cap_mim_m3_1 l=9.85 w=4.85
X53 a_7627_n1000# IBIAS VSS VSS sky130_fd_pr__nfet_01v8 ad=0.58 pd=4.29 as=0.58 ps=4.29 w=4 l=1
X54 VDD XCLK.XDB4.Y XCLK.XDB5.Y VDD sky130_fd_pr__pfet_01v8 ad=0.435 pd=3.58 as=0.435 ps=3.58 w=1.5 l=0.95
X55 VSS VSS sky130_fd_pr__cap_mim_m3_1 l=9.85 w=4.85
X56 VIN XSC.PHI1 XSC.XTG1.VOUT VSS sky130_fd_pr__nfet_01v8 ad=0.31 pd=2.62 as=0.165 ps=1.33 w=1 l=0.15
X57 VOUT VOUT a_7627_n1000# VSS sky130_fd_pr__nfet_01v8 ad=0.58 pd=4.29 as=0.58 ps=4.29 w=4 l=0.8
X58 XOTA.INP VSS sky130_fd_pr__cap_mim_m3_1 l=9.85 w=4.85
X59 XOTA.INP VSS sky130_fd_pr__cap_mim_m3_1 l=9.85 w=4.85
X60 VSS XCLK.XDA2.A XCLK.XDA2.Y VSS sky130_fd_pr__nfet_01v8 ad=0.174 pd=1.78 as=0.174 ps=1.78 w=0.6 l=0.95
X61 XOTA.INP VSS sky130_fd_pr__cap_mim_m3_1 l=9.85 w=4.85
X62 VSS XCLK.XDB3.Y XCLK.XDB4.Y VSS sky130_fd_pr__nfet_01v8 ad=0.174 pd=1.78 as=0.174 ps=1.78 w=0.6 l=0.95
X63 VDD XCLK.XDA4.Y XCLK.XDA6.A VDD sky130_fd_pr__pfet_01v8 ad=0.435 pd=3.58 as=0.435 ps=3.58 w=1.5 l=0.95
X64 VDD XCLK.XNAND_B.Y XCLK.XDB1.Y VDD sky130_fd_pr__pfet_01v8 ad=0.435 pd=3.58 as=0.435 ps=3.58 w=1.5 l=0.95
X65 XSC.XTG1.VOUT XSC.PHI1 VIN VSS sky130_fd_pr__nfet_01v8 ad=0.165 pd=1.33 as=0.31 ps=2.62 w=1 l=0.15
X66 VSS XCLK.XDA4.A XCLK.XDA4.Y VSS sky130_fd_pr__nfet_01v8 ad=0.174 pd=1.78 as=0.174 ps=1.78 w=0.6 l=0.95
X67 VSS IBIAS IBIAS VSS sky130_fd_pr__nfet_01v8 ad=0.58 pd=4.29 as=0.58 ps=4.29 w=4 l=1
X68 VIN XSC.PHI1_B XSC.XTG1.VOUT VDD sky130_fd_pr__pfet_01v8 ad=0.93 pd=6.62 as=0.495 ps=3.33 w=3 l=0.15
X69 XSC.PHI2_B XSC.PHI2 VDD VDD sky130_fd_pr__pfet_01v8 ad=0.93 pd=6.62 as=0.495 ps=3.33 w=3 l=0.15
X70 VSS IBIAS a_7627_n1000# VSS sky130_fd_pr__nfet_01v8 ad=0.58 pd=4.29 as=0.58 ps=4.29 w=4 l=1
X71 a_7845_n1000# XOTA.INP a_7627_n1000# VSS sky130_fd_pr__nfet_01v8 ad=0.58 pd=4.29 as=0.58 ps=4.29 w=4 l=0.8
X72 VSS XCLK.XNAND_B.A XSC.PHI1 VSS sky130_fd_pr__nfet_01v8 ad=0.165 pd=1.33 as=0.31 ps=2.62 w=1 l=0.15
X73 VSS IBIAS IBIAS VSS sky130_fd_pr__nfet_01v8 ad=0.58 pd=4.29 as=1.16 ps=8.58 w=4 l=1
X74 IBIAS IBIAS VSS VSS sky130_fd_pr__nfet_01v8 ad=0.58 pd=4.29 as=0.58 ps=4.29 w=4 l=1
X75 VDD XCLK.XDB6.Y XCLK.XNAND_A.Y VDD sky130_fd_pr__pfet_01v8 ad=0.58 pd=4.58 as=0.58 ps=4.58 w=2 l=0.15
X76 VSS XCLK.XDA6.A XCLK.XNAND_B.A VSS sky130_fd_pr__nfet_01v8 ad=0.174 pd=1.78 as=0.174 ps=1.78 w=0.6 l=0.95
X77 VDD XCLK.XDA6.A XCLK.XNAND_B.A VDD sky130_fd_pr__pfet_01v8 ad=0.435 pd=3.58 as=0.435 ps=3.58 w=1.5 l=0.95
X78 XOTA.INP VSS sky130_fd_pr__cap_mim_m3_1 l=9.85 w=4.85
X79 VDD XSC.PHI2 XSC.PHI2_B VDD sky130_fd_pr__pfet_01v8 ad=0.495 pd=3.33 as=0.93 ps=6.62 w=3 l=0.15
X80 XSC.XTG1.VOUT XSC.PHI1_B VIN VDD sky130_fd_pr__pfet_01v8 ad=0.495 pd=3.33 as=0.93 ps=6.62 w=3 l=0.15
X81 VDD XCLK.XDB3.Y XCLK.XDB4.Y VDD sky130_fd_pr__pfet_01v8 ad=0.435 pd=3.58 as=0.435 ps=3.58 w=1.5 l=0.95
X82 a_7627_n1000# XOTA.INP a_7845_n1000# VSS sky130_fd_pr__nfet_01v8 ad=0.58 pd=4.29 as=0.58 ps=4.29 w=4 l=0.8
X83 a_7627_n1000# VOUT VOUT VSS sky130_fd_pr__nfet_01v8 ad=0.58 pd=4.29 as=0.58 ps=4.29 w=4 l=0.8
X84 VDD a_7845_n1000# VOUT VDD sky130_fd_pr__pfet_01v8 ad=0.58 pd=4.29 as=0.58 ps=4.29 w=4 l=0.8
X85 XSC.XTG1.VOUT VSS sky130_fd_pr__cap_mim_m3_1 l=9.85 w=4.85
X86 XSC.XTG1.VOUT XSC.PHI2 XOTA.INP VSS sky130_fd_pr__nfet_01v8 ad=0.31 pd=2.62 as=0.165 ps=1.33 w=1 l=0.15
X87 VDD CLK XCLK.XNAND_B.B VDD sky130_fd_pr__pfet_01v8 ad=0.725 pd=5.58 as=0.725 ps=5.58 w=2.5 l=0.15
X88 VOUT VOUT a_7627_n1000# VSS sky130_fd_pr__nfet_01v8 ad=0.58 pd=4.29 as=0.58 ps=4.29 w=4 l=0.8
X89 a_7845_n1000# a_7845_n1000# VDD VDD sky130_fd_pr__pfet_01v8 ad=0.58 pd=4.29 as=0.58 ps=4.29 w=4 l=0.8
X90 XSC.PHI2 XCLK.XDB6.Y VSS VSS sky130_fd_pr__nfet_01v8 ad=0.31 pd=2.62 as=0.165 ps=1.33 w=1 l=0.15
X91 VSS VSS sky130_fd_pr__cap_mim_m3_1 l=9.85 w=4.85
X92 VDD XCLK.XDA2.A XCLK.XDA2.Y VDD sky130_fd_pr__pfet_01v8 ad=0.435 pd=3.58 as=0.435 ps=3.58 w=1.5 l=0.95
X93 VDD a_7845_n1000# a_7845_n1000# VDD sky130_fd_pr__pfet_01v8 ad=0.58 pd=4.29 as=0.58 ps=4.29 w=4 l=0.8
X94 VSS VSS sky130_fd_pr__cap_mim_m3_1 l=9.85 w=4.85
X95 VSS XCLK.XDB2.Y XCLK.XDB3.Y VSS sky130_fd_pr__nfet_01v8 ad=0.174 pd=1.78 as=0.174 ps=1.78 w=0.6 l=0.95
X96 XSC.PHI1 XCLK.XNAND_B.A VSS VSS sky130_fd_pr__nfet_01v8 ad=0.31 pd=2.62 as=0.165 ps=1.33 w=1 l=0.15
X97 XSC.XTG1.VOUT XSC.PHI2_B XOTA.INP VDD sky130_fd_pr__pfet_01v8 ad=0.93 pd=6.62 as=0.495 ps=3.33 w=3 l=0.15
X98 VSS XCLK.XDB6.Y XSC.PHI2 VSS sky130_fd_pr__nfet_01v8 ad=0.165 pd=1.33 as=0.31 ps=2.62 w=1 l=0.15
X99 VDD XCLK.XDA2.Y XCLK.XDA4.A VDD sky130_fd_pr__pfet_01v8 ad=0.435 pd=3.58 as=0.435 ps=3.58 w=1.5 l=0.95
X100 VSS VSS sky130_fd_pr__cap_mim_m3_1 l=9.85 w=4.85
X101 VOUT a_7845_n1000# VDD VDD sky130_fd_pr__pfet_01v8 ad=0.58 pd=4.29 as=0.58 ps=4.29 w=4 l=0.8
X102 VSS VSS sky130_fd_pr__cap_mim_m3_1 l=9.85 w=4.85
X103 a_7845_n1000# XOTA.INP a_7627_n1000# VSS sky130_fd_pr__nfet_01v8 ad=0.58 pd=4.29 as=0.58 ps=4.29 w=4 l=0.8
X104 a_7627_n1000# VOUT VOUT VSS sky130_fd_pr__nfet_01v8 ad=1.16 pd=8.58 as=0.58 ps=4.29 w=4 l=0.8
X105 VSS VSS sky130_fd_pr__cap_mim_m3_1 l=9.85 w=4.85
X106 VSS XCLK.XDB5.Y XCLK.XDB6.Y VSS sky130_fd_pr__nfet_01v8 ad=0.174 pd=1.78 as=0.174 ps=1.78 w=0.6 l=0.95
X107 VSS XCLK.XDA4.Y XCLK.XDA6.A VSS sky130_fd_pr__nfet_01v8 ad=0.174 pd=1.78 as=0.174 ps=1.78 w=0.6 l=0.95
X108 a_7627_n1000# IBIAS VSS VSS sky130_fd_pr__nfet_01v8 ad=0.58 pd=4.29 as=0.58 ps=4.29 w=4 l=1
X109 VDD XCLK.XDB2.Y XCLK.XDB3.Y VDD sky130_fd_pr__pfet_01v8 ad=0.435 pd=3.58 as=0.435 ps=3.58 w=1.5 l=0.95
X110 VSS VSS sky130_fd_pr__cap_mim_m3_1 l=9.85 w=4.85
X111 VDD XCLK.XNAND_B.A XCLK.XNAND_B.Y VDD sky130_fd_pr__pfet_01v8 ad=0.58 pd=4.58 as=0.58 ps=4.58 w=2 l=0.15
X112 VSS IBIAS a_7627_n1000# VSS sky130_fd_pr__nfet_01v8 ad=0.58 pd=4.29 as=0.58 ps=4.29 w=4 l=1
X113 VDD XCLK.XNAND_B.A XSC.PHI1 VDD sky130_fd_pr__pfet_01v8 ad=0.495 pd=3.33 as=0.93 ps=6.62 w=3 l=0.15
X114 VSS IBIAS IBIAS VSS sky130_fd_pr__nfet_01v8 ad=0.58 pd=4.29 as=0.58 ps=4.29 w=4 l=1
X115 VSS XSC.PHI1 XSC.PHI1_B VSS sky130_fd_pr__nfet_01v8 ad=0.165 pd=1.33 as=0.31 ps=2.62 w=1 l=0.15
X116 XSC.PHI1 XCLK.XNAND_B.A VDD VDD sky130_fd_pr__pfet_01v8 ad=0.93 pd=6.62 as=0.495 ps=3.33 w=3 l=0.15
X117 IBIAS IBIAS VSS VSS sky130_fd_pr__nfet_01v8 ad=0.58 pd=4.29 as=0.58 ps=4.29 w=4 l=1
X118 XSC.PHI2_B XSC.PHI2 VSS VSS sky130_fd_pr__nfet_01v8 ad=0.31 pd=2.62 as=0.165 ps=1.33 w=1 l=0.15
X119 a_n14905_n4160# XCLK.XNAND_B.A XCLK.XNAND_B.Y VSS sky130_fd_pr__nfet_01v8 ad=0.464 pd=3.78 as=0.464 ps=3.78 w=1.6 l=0.15
X120 a_7627_n1000# XOTA.INP a_7845_n1000# VSS sky130_fd_pr__nfet_01v8 ad=0.58 pd=4.29 as=0.58 ps=4.29 w=4 l=0.8
C2 XCLK.XNAND_B.Y XCLK.XNAND_B.B 0.29514f
C4 XOTA.INP VIN 0.00222f
C5 a_n14905_n4160# VDD 0.0166f
C6 CLK XCLK.XNAND_B.A 0.00128f
C7 VOUT IBIAS 0.88939f
C8 XCLK.XDB6.Y XCLK.XDB5.Y 0.59393f
C10 XSC.PHI1_B VIN 0.51773f
C11 XCLK.XDA2.Y XCLK.XNAND_A.Y 0.05171f
C14 XCLK.XDB2.Y XCLK.XDB1.Y 0.53665f
C16 a_7845_n1000# IBIAS 0.00184f
C17 XOTA.INP IBIAS 0.00867f
C18 XCLK.XNAND_A.Y a_n14905_n460# 0.23704f
C20 XCLK.XDA2.Y VDD 1.28409f
C21 XCLK.XDB1.Y XCLK.XNAND_B.Y 0.5439f
C22 XCLK.XNAND_A.Y XCLK.XNAND_B.B 0.01537f
C23 XCLK.XDB4.Y VDD 1.28412f
C25 XCLK.XDA4.A XCLK.XDA6.A 0.05623f
C26 VDD a_n14905_n460# 0.0166f
C27 XCLK.XDB2.Y XCLK.XNAND_B.Y 0.05171f
C28 VIN XCLK.XNAND_B.Y 0.00174f
C29 XCLK.XDB6.Y XSC.PHI2 0.75401f
C30 XOTA.INP XSC.PHI2 0.57033f
C31 XCLK.XDB6.Y XCLK.XNAND_A.Y 0.50345f
C32 VDD XCLK.XNAND_B.B 1.76144f
C33 XCLK.XDA2.A XCLK.XDA2.Y 0.53665f
C34 VOUT VDD 1.09404f
C35 XSC.PHI1_B XSC.PHI2 0.66695f
C36 XSC.XTG1.VOUT XSC.PHI2_B 0.5111f
C38 XCLK.XDB6.Y VDD 3.12778f
C40 a_7845_n1000# VDD 7.02572f
C41 XOTA.INP VDD 1.03785f
C42 VIN XSC.PHI2 0.08758f
C44 XSC.PHI1_B VDD 2.03257f
C45 XCLK.XDB5.Y XSC.PHI2 0.0453f
C46 XSC.PHI1_B XSC.PHI1 2.4713f
C47 VDD XCLK.XDB1.Y 1.40826f
C48 XCLK.XDA2.Y XCLK.XDA4.A 0.54082f
C49 XCLK.XDA2.A XCLK.XDB6.Y 0.04363f
C50 a_n14905_n460# CLK 0.06072f
C51 VDD XCLK.XDA4.Y 1.28412f
C52 XCLK.XDB2.Y VDD 1.28409f
C53 VDD VIN 0.86441f
C55 CLK XCLK.XNAND_B.B 0.62167f
C56 VIN XSC.PHI1 0.48086f
C57 VDD XCLK.XDB5.Y 1.41025f
C58 XCLK.XDA6.A XCLK.XNAND_B.A 0.54571f
C59 VDD XCLK.XNAND_B.Y 1.99631f
C60 XCLK.XDB6.Y CLK 0.82534f
C62 a_n14905_n4160# XCLK.XNAND_B.A 0.05301f
C63 VDD XSC.PHI2 2.91721f
C64 XSC.PHI2 XSC.PHI1 0.01692f
C65 XCLK.XNAND_A.Y VDD 2.04534f
C66 XCLK.XDB4.Y XCLK.XDB3.Y 0.53633f
C67 XCLK.XDA4.A XCLK.XDA4.Y 0.53633f
C69 XCLK.XDB6.Y XSC.PHI2_B 0.00463f
C70 XOTA.INP XSC.PHI2_B 0.3966f
C73 XSC.PHI1_B XSC.PHI2_B 0.01603f
C74 VDD XSC.PHI1 2.61405f
C75 XCLK.XDA2.A XCLK.XNAND_A.Y 0.53935f
C76 XCLK.XNAND_B.A XCLK.XNAND_B.B 0.26488f
C77 XCLK.XDB6.Y XCLK.XDB3.Y 0.00238f
C78 VIN XSC.PHI2_B 0.12966f
C79 XCLK.XDA2.A VDD 1.41152f
C80 XCLK.XDB6.Y XCLK.XNAND_B.A 0.53838f
C82 XCLK.XDB1.Y XCLK.XDB3.Y 0.05623f
C83 XCLK.XNAND_A.Y CLK 0.62938f
C84 XSC.PHI1_B XCLK.XNAND_B.A 0.00269f
C86 XCLK.XDB2.Y XCLK.XDB3.Y 0.54082f
C87 XCLK.XDB1.Y XCLK.XNAND_B.A 0.0011f
C89 XSC.XTG1.VOUT XOTA.INP 3.09363f
C90 VDD CLK 1.13971f
C91 XCLK.XDA4.Y XCLK.XNAND_B.A 0.06128f
C92 XSC.XTG1.VOUT XSC.PHI1_B 0.23028f
C93 XCLK.XDB5.Y XCLK.XDB3.Y 0.05623f
C97 XCLK.XDA4.A VDD 1.40243f
C98 a_n14905_n4160# XCLK.XNAND_B.B 0.05301f
C100 XSC.PHI2_B XSC.PHI2 3.0663f
C103 XCLK.XNAND_B.Y XCLK.XNAND_B.A 0.47697f
C104 XSC.XTG1.VOUT VIN 1.17669f
C105 XCLK.XDA2.A CLK 0.00401f
C106 XCLK.XDA2.A XCLK.XDA4.A 0.05623f
C107 a_7627_n1000# VOUT 5.02f
C108 XCLK.XDA6.A XCLK.XDA4.Y 0.54082f
C109 VDD XSC.PHI2_B 2.01819f
C111 XSC.PHI2_B XSC.PHI1 0.03008f
C113 a_7627_n1000# a_7845_n1000# 1.24812f
C114 a_7627_n1000# XOTA.INP 1.96974f
C116 XCLK.XNAND_A.Y XCLK.XNAND_B.A 0.00393f
C117 XCLK.XDB4.Y XCLK.XDB6.Y 0.06725f
C118 VDD XCLK.XDB3.Y 1.40243f
C119 XCLK.XDB6.Y a_n14905_n460# 0.05355f
C120 XSC.XTG1.VOUT XSC.PHI2 0.2892f
C121 a_n14905_n4160# XCLK.XNAND_B.Y 0.23704f
C122 XCLK.XDB6.Y XCLK.XNAND_B.B 0.2457f
C123 VDD XCLK.XNAND_B.A 2.10064f
C124 a_7845_n1000# VOUT 2.6775f
C125 XCLK.XDA2.Y XCLK.XDA4.Y 0.05623f
C126 XOTA.INP VOUT 1.70801f
C127 XCLK.XNAND_B.A XSC.PHI1 0.71679f
C128 XCLK.XDB4.Y XCLK.XDB2.Y 0.05623f
C130 XSC.XTG1.VOUT VDD 1.03607f
C131 XCLK.XDB1.Y XCLK.XNAND_B.B 0.05285f
C132 a_7627_n1000# IBIAS 2.53838f
C133 a_7845_n1000# XOTA.INP 2.82569f
C134 XSC.XTG1.VOUT XSC.PHI1 0.23203f
C136 XCLK.XDB4.Y XCLK.XDB5.Y 0.54082f
C137 XCLK.XDB2.Y XCLK.XNAND_B.B 0.0011f
C139 XCLK.XDA6.A VDD 1.4162f
C140 XOTA.INP XSC.PHI1_B 0.00161f
C141 XCLK.XDB6.Y XCLK.XDB1.Y 0.0016f
C142 XCLK.XDA6.A XSC.PHI1 0.0506f
C143 VIN VSS 10.90228f
C144 VDD VSS 0.12215p
C145 a_7627_n1000# VSS 48.52373f
C146 a_n14905_n4160# VSS 0.64193f
C147 XCLK.XDB4.Y VSS 0.63513f
C148 XCLK.XDB3.Y VSS 1.03123f
C149 XCLK.XDB1.Y VSS 1.62339f
C150 a_n14905_n460# VSS 2.89504f
C151 XSC.PHI1_B VSS 1.34566f
C152 XCLK.XDA6.A VSS 0.17775f
C153 XCLK.XDA4.A VSS 0.70531f
C154 XCLK.XDB6.Y VSS 0.35298f
.ends
