** sch_path: /headless/ANN/sky130-sc-lpf/xschem/and2_cell.sch
.subckt and2_cell A B Y VDD VSS
*.iopin VDD
*.iopin VSS
*.ipin A
*.ipin B
*.opin Y
XNAND A B net1 VDD VSS nand2_cell
XINV net1 Y VDD VSS inv_cell WN=1.0 WP=2.5 LCH=0.15
.ends

* expanding   symbol:  nand2_cell.sym # of pins=5
** sym_path: /headless/ANN/sky130-sc-lpf/xschem/nand2_cell.sym
** sch_path: /headless/ANN/sky130-sc-lpf/xschem/nand2_cell.sch
.subckt nand2_cell A B Y VDD VSS
*.iopin VDD
*.opin Y
*.iopin VSS
*.ipin A
*.ipin B
XMPA Y A VDD VDD sky130_fd_pr__pfet_01v8 L=0.15 W=2.0 nf=1 ad=0.58 as=0.58 pd=4.58 ps=4.58 nrd=0.145 nrs=0.145 sa=0 sb=0 sd=0
+ mult=1
XMPB Y B VDD VDD sky130_fd_pr__pfet_01v8 L=0.15 W=2.0 nf=1 ad=0.58 as=0.58 pd=4.58 ps=4.58 nrd=0.145 nrs=0.145 sa=0 sb=0 sd=0
+ mult=1
XMNA Y A net1 VSS sky130_fd_pr__nfet_01v8 L=0.15 W=1.6 nf=1 ad=0.464 as=0.464 pd=3.78 ps=3.78 nrd=0.18125 nrs=0.18125 sa=0 sb=0
+ sd=0 mult=1
XMNB net1 B VSS VSS sky130_fd_pr__nfet_01v8 L=0.15 W=1.6 nf=1 ad=0.464 as=0.464 pd=3.78 ps=3.78 nrd=0.18125 nrs=0.18125 sa=0 sb=0
+ sd=0 mult=1
.ends

* expanding   symbol:  inv_cell.sym # of pins=4
** sym_path: /headless/ANN/sky130-sc-lpf/xschem/inv_cell.sym
** sch_path: /headless/ANN/sky130-sc-lpf/xschem/inv_cell.sch
.subckt inv_cell A Y VDD VSS  WN=1.0 WP=2.5 LCH=0.15
*.ipin A
*.opin Y
*.iopin VDD
*.iopin VSS
XMP Y A VDD VDD sky130_fd_pr__pfet_01v8 L='LCH' W='WP' nf=1 ad='WP*0.29' as='WP*0.29' pd='2*(WP+0.29)' ps='2*(WP+0.29)' nrd='0.29/WP'
+ nrs='0.29/WP' sa=0 sb=0 sd=0 mult=1
XMN Y A VSS VSS sky130_fd_pr__nfet_01v8 L='LCH' W='WN' nf=1 ad='WN*0.29' as='WN*0.29' pd='2*(WN+0.29)' ps='2*(WN+0.29)' nrd='0.29/WN'
+ nrs='0.29/WN' sa=0 sb=0 sd=0 mult=1
.ends
