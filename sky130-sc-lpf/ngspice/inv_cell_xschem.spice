** sch_path: /headless/ANN/sky130-sc-lpf/xschem/inv_cell.sch
.subckt inv_cell A Y VDD VSS
*.ipin A
*.opin Y
*.iopin VDD
*.iopin VSS
XMP Y A VDD VDD sky130_fd_pr__pfet_01v8 L='LCH' W='WP' nf=1 ad='WP*0.29' as='WP*0.29' pd='2*(WP+0.29)' ps='2*(WP+0.29)' nrd='0.29/WP'
+ nrs='0.29/WP' sa=0 sb=0 sd=0 mult=1
XMN Y A VSS VSS sky130_fd_pr__nfet_01v8 L='LCH' W='WN' nf=1 ad='WN*0.29' as='WN*0.29' pd='2*(WN+0.29)' ps='2*(WN+0.29)' nrd='0.29/WN'
+ nrs='0.29/WN' sa=0 sb=0 sd=0 mult=1
.ends
