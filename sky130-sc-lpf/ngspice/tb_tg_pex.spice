* Week 4 Task 4.3b Testbench: CMOS Transmission Gate On-Resistance Sweep (Post-Layout PEX)
.lib "/foss/pdks/sky130A/libs.tech/combined/sky130.lib.spice" tt
.temp 27

.include "/headless/ANN/sky130-sc-lpf/layout/tg_switch_pex.spice"

Vdd  vdd   0 1.8
Vss  vss   0 0.0
Vphi phi   0 1.8
Vphb phi_b 0 0.0

Vin  vin   0 0.0
Vtst vout  vin 1m

XTG  vin vout phi phi_b vdd vss tg_switch

.control
set ngbehavior=hsa
set ng_nomodcheck
dc Vin 0 1.8 0.005
let ron_tg_kohm = (1m / abs(i(Vtst))) / 1e3
write /headless/ANN/sky130-sc-lpf/ngspice/tb_tg_pex.raw ron_tg_kohm
wrdata /headless/ANN/sky130-sc-lpf/ngspice/tb_tg_pex.txt ron_tg_kohm

meas dc ron_at_vcm_kohm find ron_tg_kohm at=0.9
meas dc ron_max_sig_kohm max ron_tg_kohm from=0.5 to=1.3
meas dc ron_max_rail_kohm max ron_tg_kohm from=0.0 to=1.8
meas dc ron_min_rail_kohm min ron_tg_kohm from=0.0 to=1.8
quit
.endc
.end
