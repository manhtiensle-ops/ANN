** sch_path: /headless/ANN/sky130-sc-lpf/xschem/top_sc_lpf.sch
.subckt top_sc_lpf VIN CLK IBIAS VOUT VDD VSS
*.iopin VDD
*.iopin VSS
*.ipin CLK
*.ipin VIN
*.ipin IBIAS
*.opin VOUT
XCLK CLK net1 net2 net3 net4 VDD VSS non_overlap_clk
XSC VIN net5 net1 net2 net3 net4 VDD VSS sc_core
XOTA net5 VOUT IBIAS VOUT VDD VSS ota_5t
.ends

* expanding   symbol:  non_overlap_clk.sym # of pins=7
** sym_path: /headless/ANN/sky130-sc-lpf/xschem/non_overlap_clk.sym
** sch_path: /headless/ANN/sky130-sc-lpf/xschem/non_overlap_clk.sch
.subckt non_overlap_clk CLK PHI1 PHI1_B PHI2 PHI2_B VDD VSS
*.iopin VDD
*.iopin VSS
*.ipin CLK
*.opin PHI1
*.opin PHI1_B
*.opin PHI2
*.opin PHI2_B
XINV0 CLK net1 VDD VSS inv_cell WN=1.0 WP=2.5 LCH=0.15
XNAND_A CLK net15 net2 VDD VSS nand2_cell
XNAND_B net14 net1 net3 VDD VSS nand2_cell
XDA1 net2 net4 VDD VSS inv_cell WN=0.6 WP=1.5 LCH=0.95
XDB1 net3 net5 VDD VSS inv_cell WN=0.6 WP=1.5 LCH=0.95
XDA2 net4 net6 VDD VSS inv_cell WN=0.6 WP=1.5 LCH=0.95
XDB2 net5 net7 VDD VSS inv_cell WN=0.6 WP=1.5 LCH=0.95
XDA3 net6 net8 VDD VSS inv_cell WN=0.6 WP=1.5 LCH=0.95
XDB3 net7 net9 VDD VSS inv_cell WN=0.6 WP=1.5 LCH=0.95
XDA4 net8 net10 VDD VSS inv_cell WN=0.6 WP=1.5 LCH=0.95
XDB4 net9 net11 VDD VSS inv_cell WN=0.6 WP=1.5 LCH=0.95
XDA5 net10 net12 VDD VSS inv_cell WN=0.6 WP=1.5 LCH=0.95
XDB5 net11 net13 VDD VSS inv_cell WN=0.6 WP=1.5 LCH=0.95
XDA6 net12 net14 VDD VSS inv_cell WN=0.6 WP=1.5 LCH=0.95
XDB6 net13 net15 VDD VSS inv_cell WN=0.6 WP=1.5 LCH=0.95
XBUF1A net14 PHI1 VDD VSS inv_cell WN=2.0 WP=6.0 LCH=0.15
XBUF1B PHI1 PHI1_B VDD VSS inv_cell WN=2.0 WP=6.0 LCH=0.15
XBUF2A net15 PHI2 VDD VSS inv_cell WN=2.0 WP=6.0 LCH=0.15
XBUF2B PHI2 PHI2_B VDD VSS inv_cell WN=2.0 WP=6.0 LCH=0.15
.ends

* expanding   symbol:  sc_core.sym # of pins=8
** sym_path: /headless/ANN/sky130-sc-lpf/xschem/sc_core.sym
** sch_path: /headless/ANN/sky130-sc-lpf/xschem/sc_core.sch
.subckt sc_core VIN VX PHI1 PHI1_B PHI2 PHI2_B VDD VSS
*.iopin VDD
*.iopin VSS
*.ipin PHI1
*.ipin PHI1_B
*.ipin PHI2
*.ipin PHI2_B
*.ipin VIN
*.opin VX
XTG1 VIN net1 PHI1 PHI1_B VDD VSS tg_switch
XC1 net1 VSS sky130_fd_pr__cap_mim_m3_1 W=4.85 L=9.85 MF=1
XTG2 net1 VX PHI2 PHI2_B VDD VSS tg_switch
XC2 VX VSS sky130_fd_pr__cap_mim_m3_1 W=4.85 L=9.85 MF=8 m=8
XDUM2 VX PHI2_B PHI2 VDD VSS tg_dummy
.ends

* expanding   symbol:  ota_5t.sym # of pins=6
** sym_path: /headless/ANN/sky130-sc-lpf/xschem/ota_5t.sym
** sch_path: /headless/ANN/sky130-sc-lpf/xschem/ota_5t.sch
.subckt ota_5t INP INN IBIAS VOUT VDD VSS
*.iopin VDD
*.opin VOUT
*.ipin INP
*.ipin INN
*.ipin IBIAS
*.iopin VSS
XM3 net1 net1 VDD VDD sky130_fd_pr__pfet_01v8 L=0.80 W=16.0 nf=4 ad=2.32 as=3.48 pd=17.16 ps=25.74 nrd=0.018125 nrs=0.018125 sa=0
+ sb=0 sd=0 mult=1
XM4 VOUT net1 VDD VDD sky130_fd_pr__pfet_01v8 L=0.80 W=16.0 nf=4 ad=2.32 as=3.48 pd=17.16 ps=25.74 nrd=0.018125 nrs=0.018125 sa=0
+ sb=0 sd=0 mult=1
XM1 net1 INP net2 VSS sky130_fd_pr__nfet_01v8 L=0.80 W=32.0 nf=8 ad=4.64 as=5.8 pd=34.32 ps=42.9 nrd=0.0090625 nrs=0.0090625 sa=0
+ sb=0 sd=0 mult=1
XM2 VOUT INN net2 VSS sky130_fd_pr__nfet_01v8 L=0.80 W=32.0 nf=8 ad=4.64 as=5.8 pd=34.32 ps=42.9 nrd=0.0090625 nrs=0.0090625 sa=0
+ sb=0 sd=0 mult=1
XM5 net2 IBIAS VSS VSS sky130_fd_pr__nfet_01v8 L=1.00 W=24.0 nf=6 ad=3.48 as=4.64 pd=25.74 ps=34.32 nrd=0.0120833333333333
+ nrs=0.0120833333333333 sa=0 sb=0 sd=0 mult=1
XM6 IBIAS IBIAS VSS VSS sky130_fd_pr__nfet_01v8 L=1.00 W=24.0 nf=6 ad=3.48 as=4.64 pd=25.74 ps=34.32 nrd=0.0120833333333333
+ nrs=0.0120833333333333 sa=0 sb=0 sd=0 mult=1
.ends

* expanding   symbol:  inv_cell.sym # of pins=4
** sym_path: /headless/ANN/sky130-sc-lpf/xschem/inv_cell.sym
** sch_path: /headless/ANN/sky130-sc-lpf/xschem/inv_cell.sch
.subckt inv_cell A Y VDD VSS  WN=1.0 WP=2.5 LCH=0.15
*.ipin A
*.opin Y
*.iopin VDD
*.iopin VSS
XMP Y A VDD VDD sky130_fd_pr__pfet_01v8 L='LCH' W='WP' nf=1 ad='WP*0.29' as='WP*0.29' pd='2*(WP+0.29)' ps='2*(WP+0.29)' nrd='0.29/WP'
+ nrs='0.29/WP' sa=0 sb=0 sd=0 mult=1
XMN Y A VSS VSS sky130_fd_pr__nfet_01v8 L='LCH' W='WN' nf=1 ad='WN*0.29' as='WN*0.29' pd='2*(WN+0.29)' ps='2*(WN+0.29)' nrd='0.29/WN'
+ nrs='0.29/WN' sa=0 sb=0 sd=0 mult=1
.ends

* expanding   symbol:  nand2_cell.sym # of pins=5
** sym_path: /headless/ANN/sky130-sc-lpf/xschem/nand2_cell.sym
** sch_path: /headless/ANN/sky130-sc-lpf/xschem/nand2_cell.sch
.subckt nand2_cell A B Y VDD VSS
*.iopin VDD
*.opin Y
*.iopin VSS
*.ipin A
*.ipin B
XMPA Y A VDD VDD sky130_fd_pr__pfet_01v8 L=0.15 W=2.0 nf=1 ad=0.58 as=0.58 pd=4.58 ps=4.58 nrd=0.145 nrs=0.145 sa=0 sb=0 sd=0
+ mult=1
XMPB Y B VDD VDD sky130_fd_pr__pfet_01v8 L=0.15 W=2.0 nf=1 ad=0.58 as=0.58 pd=4.58 ps=4.58 nrd=0.145 nrs=0.145 sa=0 sb=0 sd=0
+ mult=1
XMNA Y A net1 VSS sky130_fd_pr__nfet_01v8 L=0.15 W=1.6 nf=1 ad=0.464 as=0.464 pd=3.78 ps=3.78 nrd=0.18125 nrs=0.18125 sa=0 sb=0
+ sd=0 mult=1
XMNB net1 B VSS VSS sky130_fd_pr__nfet_01v8 L=0.15 W=1.6 nf=1 ad=0.464 as=0.464 pd=3.78 ps=3.78 nrd=0.18125 nrs=0.18125 sa=0 sb=0
+ sd=0 mult=1
.ends

* expanding   symbol:  tg_switch.sym # of pins=6
** sym_path: /headless/ANN/sky130-sc-lpf/xschem/tg_switch.sym
** sch_path: /headless/ANN/sky130-sc-lpf/xschem/tg_switch.sch
.subckt tg_switch VIN VOUT PHI PHI_B VDD VSS
*.iopin VIN
*.iopin VOUT
*.ipin PHI_B
*.ipin PHI
*.iopin VDD
*.iopin VSS
XMP VOUT PHI_B VIN VDD sky130_fd_pr__pfet_01v8 L=0.15 W=6.0 nf=2 ad=0.87 as=1.74 pd=6.58 ps=13.16 nrd=0.0483333333333333
+ nrs=0.0483333333333333 sa=0 sb=0 sd=0 mult=1
XMN VOUT PHI VIN VSS sky130_fd_pr__nfet_01v8 L=0.15 W=2.0 nf=1 ad=0.58 as=0.58 pd=4.58 ps=4.58 nrd=0.145 nrs=0.145 sa=0 sb=0 sd=0
+ mult=1
.ends

* expanding   symbol:  tg_dummy.sym # of pins=5
** sym_path: /headless/ANN/sky130-sc-lpf/xschem/tg_dummy.sym
** sch_path: /headless/ANN/sky130-sc-lpf/xschem/tg_dummy.sch
.subckt tg_dummy VNODE G_N G_P VDD VSS
*.iopin VNODE
*.ipin G_P
*.ipin G_N
*.iopin VDD
*.iopin VSS
XMPD VNODE G_P VNODE VDD sky130_fd_pr__pfet_01v8 L=0.15 W=3.0 nf=1 ad=0.87 as=0.87 pd=6.58 ps=6.58 nrd=0.0966666666666667
+ nrs=0.0966666666666667 sa=0 sb=0 sd=0 mult=1
XMND VNODE G_N VNODE VSS sky130_fd_pr__nfet_01v8 L=0.15 W=1.0 nf=1 ad=0.29 as=0.29 pd=2.58 ps=2.58 nrd=0.29 nrs=0.29 sa=0 sb=0
+ sd=0 mult=1
.ends
