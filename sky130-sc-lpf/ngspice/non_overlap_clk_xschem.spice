** sch_path: /headless/ANN/sky130-sc-lpf/xschem/non_overlap_clk.sch
.subckt non_overlap_clk CLK PHI1 PHI1_B PHI2 PHI2_B VDD VSS
*.iopin VDD
*.iopin VSS
*.ipin CLK
*.opin PHI1
*.opin PHI1_B
*.opin PHI2
*.opin PHI2_B
XINV0 CLK net1 VDD VSS inv_cell WN=1.0 WP=2.5 LCH=0.15
XNAND_A CLK net15 net2 VDD VSS nand2_cell
XNAND_B net14 net1 net3 VDD VSS nand2_cell
XDA1 net2 net4 VDD VSS inv_cell WN=0.6 WP=1.5 LCH=0.95
XDB1 net3 net5 VDD VSS inv_cell WN=0.6 WP=1.5 LCH=0.95
XDA2 net4 net6 VDD VSS inv_cell WN=0.6 WP=1.5 LCH=0.95
XDB2 net5 net7 VDD VSS inv_cell WN=0.6 WP=1.5 LCH=0.95
XDA3 net6 net8 VDD VSS inv_cell WN=0.6 WP=1.5 LCH=0.95
XDB3 net7 net9 VDD VSS inv_cell WN=0.6 WP=1.5 LCH=0.95
XDA4 net8 net10 VDD VSS inv_cell WN=0.6 WP=1.5 LCH=0.95
XDB4 net9 net11 VDD VSS inv_cell WN=0.6 WP=1.5 LCH=0.95
XDA5 net10 net12 VDD VSS inv_cell WN=0.6 WP=1.5 LCH=0.95
XDB5 net11 net13 VDD VSS inv_cell WN=0.6 WP=1.5 LCH=0.95
XDA6 net12 net14 VDD VSS inv_cell WN=0.6 WP=1.5 LCH=0.95
XDB6 net13 net15 VDD VSS inv_cell WN=0.6 WP=1.5 LCH=0.95
XBUF1A net14 PHI1 VDD VSS inv_cell WN=2.0 WP=6.0 LCH=0.15
XBUF1B PHI1 PHI1_B VDD VSS inv_cell WN=2.0 WP=6.0 LCH=0.15
XBUF2A net15 PHI2 VDD VSS inv_cell WN=2.0 WP=6.0 LCH=0.15
XBUF2B PHI2 PHI2_B VDD VSS inv_cell WN=2.0 WP=6.0 LCH=0.15
.ends

* expanding   symbol:  inv_cell.sym # of pins=4
** sym_path: /headless/ANN/sky130-sc-lpf/xschem/inv_cell.sym
** sch_path: /headless/ANN/sky130-sc-lpf/xschem/inv_cell.sch
.subckt inv_cell A Y VDD VSS  WN=1.0 WP=2.5 LCH=0.15
*.ipin A
*.opin Y
*.iopin VDD
*.iopin VSS
XMP Y A VDD VDD sky130_fd_pr__pfet_01v8 L='LCH' W='WP' nf=1 ad='WP*0.29' as='WP*0.29' pd='2*(WP+0.29)' ps='2*(WP+0.29)' nrd='0.29/WP'
+ nrs='0.29/WP' sa=0 sb=0 sd=0 mult=1
XMN Y A VSS VSS sky130_fd_pr__nfet_01v8 L='LCH' W='WN' nf=1 ad='WN*0.29' as='WN*0.29' pd='2*(WN+0.29)' ps='2*(WN+0.29)' nrd='0.29/WN'
+ nrs='0.29/WN' sa=0 sb=0 sd=0 mult=1
.ends

* expanding   symbol:  nand2_cell.sym # of pins=5
** sym_path: /headless/ANN/sky130-sc-lpf/xschem/nand2_cell.sym
** sch_path: /headless/ANN/sky130-sc-lpf/xschem/nand2_cell.sch
.subckt nand2_cell A B Y VDD VSS
*.iopin VDD
*.opin Y
*.iopin VSS
*.ipin A
*.ipin B
XMPA Y A VDD VDD sky130_fd_pr__pfet_01v8 L=0.15 W=2.0 nf=1 ad=0.58 as=0.58 pd=4.58 ps=4.58 nrd=0.145 nrs=0.145 sa=0 sb=0 sd=0
+ mult=1
XMPB Y B VDD VDD sky130_fd_pr__pfet_01v8 L=0.15 W=2.0 nf=1 ad=0.58 as=0.58 pd=4.58 ps=4.58 nrd=0.145 nrs=0.145 sa=0 sb=0 sd=0
+ mult=1
XMNA Y A net1 VSS sky130_fd_pr__nfet_01v8 L=0.15 W=1.6 nf=1 ad=0.464 as=0.464 pd=3.78 ps=3.78 nrd=0.18125 nrs=0.18125 sa=0 sb=0
+ sd=0 mult=1
XMNB net1 B VSS VSS sky130_fd_pr__nfet_01v8 L=0.15 W=1.6 nf=1 ad=0.464 as=0.464 pd=3.78 ps=3.78 nrd=0.18125 nrs=0.18125 sa=0 sb=0
+ sd=0 mult=1
.ends
